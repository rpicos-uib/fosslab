// SOLUTION of the exercise (teachers only): the model with a second pole.
// Behavioural model of the FOSSLab tutorial op-amp (IHP SG13G2).
// Two poles, slew-rate limit, output limited near the rails.
// Same pins as the transistor-level cell, so it can replace it.
`include "constants.vams"
`include "disciplines.vams"

module opamp_2pole(INP, INN, OUT, IBIAS, VDD, VSS);
    inout INP, INN, OUT, IBIAS, VDD, VSS;
    electrical INP, INN, OUT, IBIAS, VDD, VSS;
    electrical n1;                      // internal node: the dominant pole
    electrical n2;                      // internal node: the second pole

    parameter real A0dB    = 57.6;      // DC gain (dB)
    parameter real GBW     = 18.6e6;    // gain-bandwidth product (Hz)
    parameter real VOS     = 1.98e-3;   // input-referred offset (V)
    parameter real FP2     = 28.44e6;   // second pole (Hz)
    parameter real SR      = 10.6e6;    // slew rate (V/s)
    parameter real ROUT    = 100.0;     // output resistance (ohm)
    parameter real VMARGIN = 0.1;       // the output stays this far from the rails (V)
    parameter real IDD     = 65.7e-6;   // supply current, without IBIAS (A)
    parameter real RBIAS   = 40e3;      // IBIAS input looks like a diode-connected MOS

    real a0, gm, r1, c1, imax, vmid, vlo, vhi, vt, r2, c2;

    // smooth max(x, 0), so the output limit has a continuous derivative
    analog function real softplus;
        input x;
        real x;
        softplus = 0.02 * ln(1 + exp(x / 0.02));
    endfunction

    analog begin
        a0   = pow(10, A0dB / 20);
        gm   = 1e-3;                    // any value: only gm*r1 and gm/c1 matter
        r1   = a0 / gm;                 // DC gain a0 = gm * r1
        c1   = gm / (2 * `M_PI * GBW);  // unity gain at GBW: gm / (2 pi c1)
        imax = SR * c1;                 // slewing: c1 charged at most with imax
        vmid = (V(VDD) + V(VSS)) / 2;

        // input stage: limited transconductance into r1 // c1
        I(n1, VSS) <+ -imax * tanh(gm * (V(INP, INN) + VOS) / imax);
        I(n1, VSS) <+ (V(n1) - vmid) / r1;
        I(n1, VSS) <+ c1 * ddt(V(n1, VSS));

        // second pole: n2 follows n1 through r2-c2 (unity gain, pole at FP2)
        r2 = 1e3;
        c2 = 1 / (2 * `M_PI * FP2 * r2);
        I(n2, VSS) <+ (V(n2) - V(n1)) / r2;
        I(n2, VSS) <+ c2 * ddt(V(n2, VSS));

        // output: follows n2, limited to [VSS + VMARGIN, VDD - VMARGIN]
        vlo = V(VSS) + VMARGIN;
        vhi = V(VDD) - VMARGIN;
        vt  = V(n2) - softplus(V(n2) - vhi) + softplus(vlo - V(n2));
        I(OUT, VSS) <+ (V(OUT) - vt) / ROUT;

        // supply current and bias input
        I(VDD, VSS)   <+ IDD;
        I(IBIAS, VSS) <+ V(IBIAS, VSS) / RBIAS;
    end
endmodule
